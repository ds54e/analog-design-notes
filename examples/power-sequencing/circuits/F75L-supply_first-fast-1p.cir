* ADS finite resistive feedback amplifier; explicit D G S B terminals.
Vdd vdd 0 DC 1 AC 0 PWL(0 1 1.9999999999999999e-06 1 2.0099999999999998e-06 1 2.0000000000000002e-05 1)
Vin in 0 DC 0 AC 1 PWL(0 0 1.9999999999999999e-06 0 2.0099999999999998e-06 0.45000000000000001 2.0000000000000002e-05 0.45000000000000001)
Rsrc in drive 1000
Rin drive gate 9000
Rf out gate 100000
Rs source 0 670.36609929543783
Rload out 0 100000
Cload capnode 0 9.9999999999999998e-13
Idist 0 out DC 0 AC 0
Vbiasdiag pbias pdrive DC 0 AC 0
Rbias pbias 0 10731.024577367358
Vn0d out n0d 0
Vn0g gate n0g 0
Vn0s source n0s 0
Vn0b 0 n0b 0
xn0 n0d n0g n0s n0b apm045_vtg_nmos w=3.9999999999997931e-06 l=3.9999999999999998e-07
Vn1d out n1d 0
Vn1g gate n1g 0
Vn1s source n1s 0
Vn1b 0 n1b 0
xn1 n1d n1g n1s n1b apm045_vtg_nmos w=3.9999999999997931e-06 l=3.9999999999999998e-07
Vn2d out n2d 0
Vn2g gate n2g 0
Vn2s source n2s 0
Vn2b 0 n2b 0
xn2 n2d n2g n2s n2b apm045_vtg_nmos w=3.9999999999997931e-06 l=3.9999999999999998e-07
Vr0d pbias r0d 0
Vr0g pbias r0g 0
Vr0s vdd r0s 0
Vr0b vdd r0b 0
xr0 r0d r0g r0s r0b apm045_vtg_pmos w=3.3333333333333333e-06 l=3.9999999999999998e-07
Vp0d out p0d 0
Vp0g pdrive p0g 0
Vp0s vdd p0s 0
Vp0b vdd p0b 0
xp0 p0d p0g p0s p0b apm045_vtg_pmos w=3.3333333333333333e-06 l=3.9999999999999998e-07
Vcap out capnode 0
