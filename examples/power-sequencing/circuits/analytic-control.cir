* ADS finite resistive feedback amplifier; explicit D G S B terminals.
Vdd vdd 0 DC 0 AC 0 PWL(0 0 2.0000000000000002e-05 0)
Vin in 0 DC 0 AC 1 PWL(0 0 1.9999999999999999e-06 0 3.0000000000000001e-06 0.45000000000000001 2.0000000000000002e-05 0.45000000000000001)
Rsrc in drive 1000
Rin drive gate 9000
Rf out gate 100000
Rs source 0 670.36609929543783
Rload out 0 100000
Cload capnode 0 7.9999999999999998e-12
Idist 0 out DC 0 AC 0
Vbiasdiag pbias pdrive DC 0 AC 0
Rbias pbias 0 10731.024577367358
Vcap out capnode 0
